* Ideal non-inverting active filter; project-specific .OPAMP extension
V1 IN 0 AC 20 0
C1 IN N1 10n
C2 N1 NP 10n
G1 N1 OUT 100u
G2 NP 0 100u
RA NM 0 10k
RB OUT NM 10k
.OPAMP U1 NP NM OUT IDEAL
.AC DEC 10 1 1Meg
.END
