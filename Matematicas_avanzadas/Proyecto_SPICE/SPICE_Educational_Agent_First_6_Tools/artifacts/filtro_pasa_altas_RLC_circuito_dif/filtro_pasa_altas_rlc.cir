* Filtro pasa-altas RLC serie (nodos en mayusculas para parser educativo)
V1 IN 0 AC 1 0
C1 IN N1 1u
L1 N1 OUT 10m
R1 OUT 0 1k
.AC LIN 400 10 100k
.END
