* Filtro activo objetivo, valores tomados del diagrama suministrado
V1 IN 0 AC 1m 0
C1 IN N1 0.1u
C2 N1 NP 0.1u
G1 N1 OUT 0.00078740157480315
G2 NP 0 0.000434782608695652
RB OUT NM 2.3k
RA NM 0 1.27k
.OPAMP U1 NP NM OUT IDEAL
.AC LIN 300 10 100k
.END
